* Qucs 26.1.0  C:/Users/Administrator/Desktop/1ab7903b-c2b9-4ea8-b6ae-c888b38d4636/Anti_aliasing_filter_prj/anti_filter.sch
.INCLUDE "C:/Program Files/Qucs-S/share/qucs-s/xspice_cmlib/include/ngspice_mathfunc.inc"
.PARAM y=1
B_OP1 _net1 0 V = 1E6*V(0,_net0)*u(15-1E6*V(0,_net0))*u(1E6*V(0,_net0)-(-15))+15*u(1E6*V(0,_net0)-15)+(-15)*u((-15)-1E6*V(0,_net0))
C1 _net0 _net1  1N
R3 _net2 _net3  13.48KΩ tc1=0.0 tc2=0.0
R1 _net3 _net1  13.48KΩ tc1=0.0 tc2=0.0
R2 _net3 _net0  1.93KΩ tc1=0.0 tc2=0.0
C2 0 _net3  3N
B_OP2 _net5 0 V = 1E6*V(0,_net4)*u(15-1E6*V(0,_net4))*u(1E6*V(0,_net4)-(-15))+15*u(1E6*V(0,_net4)-15)+(-15)*u((-15)-1E6*V(0,_net4))
C4 0 _net6  3N
B_OP3 _net8 0 V = 1E6*V(0,_net7)*u(15-1E6*V(0,_net7))*u(1E6*V(0,_net7)-(-15))+15*u(1E6*V(0,_net7)-15)+(-15)*u((-15)-1E6*V(0,_net7))
C5 _net7 _net8  1N
B_OP4 VADC 0 V = 1E6*V(0,_net9)*u(15-1E6*V(0,_net9))*u(1E6*V(0,_net9)-(-15))+15*u(1E6*V(0,_net9)-15)+(-15)*u((-15)-1E6*V(0,_net9))
C7 _net9 VADC  1N
R4 _net1 _net6  8.75KΩ tc1=0.0 tc2=0.0
R5 _net6 _net5  8.75KΩ tc1=0.0 tc2=0.0
C3 _net4 _net5  1N
R6 _net6 _net4  2.98KΩ tc1=0.0 tc2=0.0
R7 _net5 _net10  6.25KΩ tc1=0.0 tc2=0.0
R8 _net10 _net8  6.25KΩ tc1=0.0 tc2=0.0
R9 _net10 _net7  1.79KΩ tc1=0.0 tc2=0.0
C6 0 _net10  7N
R10 _net8 _net11  1.89KΩ tc1=0.0 tc2=0.0
R11 _net11 VADC  1.89KΩ tc1=0.0 tc2=0.0
R12 _net11 _net9  782Ω tc1=0.0 tc2=0.0
C8 0 _net11  53N
V2 _net2 0 DC 1.65 SIN(1.65 1 1K 0 0 0) AC 1 ACPHASE 0
R13 0 VADC  100MEG tc1=0.0 tc2=0.0

.control

let y=1
ac dec 100 10 200k
let Gain_dB=20*log10(abs(V(vadc)))
write spice4qucs.ac1.plot v(VADC) Gain_dB
destroy all
reset

exit
.endc
.END
