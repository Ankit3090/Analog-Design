* Qucs 26.1.0  C:/Users/Administrator/Desktop/527c3a35-4eee-491d-943f-e55cd0fcdb30/Close_loop_buck_prj/closed_loop_buck_qucs.sch
.INCLUDE "C:/Program Files/Qucs-S/share/qucs-s/xspice_cmlib/include/ngspice_mathfunc.inc"
.INCLUDE "C:\Program Files\Qucs-S\share\qucs-s\spicelibrary\spdt.cir"
L1 _net0 _net1  100U
VIL _net1 VOUT DC 0
C1 _net2 VOUT  100U
VILOAD VOUT _net3 DC 0
R2 0 _net3  10 tc1=0.0 tc2=0.0
R1 0 _net2  0.05 tc1=0.0 tc2=0.0
R3 _net4 _net3  10 tc1=0.0 tc2=0.0
S1 0 _net4 control_netS1 0 switch_modelS1
VS1 control_netS1 0 DC 0 PWL(0 0 0.002475 0 0.0025 1)
.model switch_modelS1 sw vt =0.5 ron =1E-9 roff =1E12
V2 VREF 0 DC 5
ESRC1 VERR 0 VREF FB 20
ESRC2 _net5 SW PWM 0 10
R4 VOUT FB  0.1U tc1=0.0 tc2=0.0
V3 VSAW 0 DC 0 PULSE(0 1 0 9.9U 0.1U {(10U)-(0)-(9.9U)-(0.1U)}) AC 0
MT1 Vin _net6 SW SW MMOD_T1 L=1e-06 W=1e-06 Ad=0 As=0 Pd=0 Ps=0
.MODEL MMOD_T1 NMOS (Vt0=1.0 Kp=100 Gamma=0.0 Phi=0.6 Lambda=0.0 Rd=0.0 Rs=0.0 Is=1E-14 Ld=0.0 Tox=0.1UM Cgso=0.0 Cgdo=0.0 Cgbo=0.0 Cbd=0.0 Cbs=0.0 Pb=0.8 Mj=0.5 Fc=0.5 Cjsw=0.0 Mjsw=0.33 Tpg=1 Uo=600.0 Rsh=0.0 Cj=0.0 Js=0.0 Kf=0.0 Af=1.0 Tnom=26.85 )
B1 _net7  0  V = V(VERR) > V(VSAW) ? 1 : 0
D1 0 SW DMOD_D1 AREA=1.0
.MODEL DMOD_D1 D (Is=1E-15 N=1 Cj0=0 M=0.5 Vj=0.7 Fc=0.5 Rs=0.0 Tt=0.0P Kf=0.0 Af=1.0 Bv=10 Ibv=1M Xti=3.0 Eg=1.11 Tcv=0.0 Trs=0.0 Ttt1=0.0 Ttt2=0.0 Tm1=0.0 Tm2=0.0 Tnom=26.85 )
R5 _net0 SW  0.01 tc1=0.0 tc2=0.0
R6 _net6 _net5  10 tc1=0.0 tc2=0.0
V4 Vin 0 DC 0 PULSE(0 12 1U 1U 1U {(100M)-(1U)-(1U)-(1U)}) AC 0
R7 PWM _net7  100 tc1=0.0 tc2=0.0
C2 0 PWM  100P

.control

tran 2e-07 0.005 0
write spice4qucs.tr1.plot v(FB) v(PWM) v(SW) v(VERR) i(VIL) i(VILOAD) v(VOUT) v(VREF) v(VSAW) v(Vin)
destroy all
reset

exit
.endc
.END
