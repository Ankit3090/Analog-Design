* Qucs 26.1.0  C:/Users/Administrator/Desktop/0bceac8e-d045-4368-a050-b0931ccf9ed3/ACTIVE-MIXER_prj/ACTIVE-MIXER-MODEL.sch
.INCLUDE "C:/Program Files/Qucs-S/share/qucs-s/xspice_cmlib/include/ngspice_mathfunc.inc"
QT2 pos _net0 _net1 QMOD_T2 AREA=1.0
.MODEL QMOD_T2 npn (Is=1E-16 Nf=1 Nr=1 Ikf=0 Ikr=0 Vaf=0 Var=0 Ise=0 Ne=1.5 Isc=0 Nc=2 Bf=200 Br=1 Rbm=0 Irb=0 Rc=0 Re=0 Rb=0 Cje=0 Vje=0.75 Mje=0.33 Cjc=0 Vjc=0.75 Mjc=0.33 Xcjc=1.0 Cjs=0 Vjs=0.75 Mjs=0 Fc=0.5 Tf=0.0 Xtf=0.0 Vtf=0.0 Itf=0.0 Tr=0.0 Kf=0.0 Af=1.0 Ptf=0.0 Xtb=0.0 Xti=3.0 Eg=1.11 Tnom=26.85 )
QT3 neg _net2 _net1 QMOD_T3 AREA=1.0
.MODEL QMOD_T3 npn (Is=1E-16 Nf=1 Nr=1 Ikf=0 Ikr=0 Vaf=0 Var=0 Ise=0 Ne=1.5 Isc=0 Nc=2 Bf=200 Br=1 Rbm=0 Irb=0 Rc=0 Re=0 Rb=0 Cje=0 Vje=0.75 Mje=0.33 Cjc=0 Vjc=0.75 Mjc=0.33 Xcjc=1.0 Cjs=0 Vjs=0.75 Mjs=0 Fc=0.5 Tf=0.0 Xtf=0.0 Vtf=0.0 Itf=0.0 Tr=0.0 Kf=0.0 Af=1.0 Ptf=0.0 Xtb=0.0 Xti=3.0 Eg=1.11 Tnom=26.85 )
QT1 _net1 _net4 0 QMOD_T1 AREA=1.0
.MODEL QMOD_T1 npn (Is=1E-16 Nf=1 Nr=1 Ikf=0 Ikr=0 Vaf=0 Var=0 Ise=0 Ne=1.5 Isc=0 Nc=2 Bf=200 Br=1 Rbm=0 Irb=0 Rc=0 Re=0 Rb=0 Cje=0 Vje=0.75 Mje=0.33 Cjc=0 Vjc=0.75 Mjc=0.33 Xcjc=1.0 Cjs=0 Vjs=0.75 Mjs=0 Fc=0.5 Tf=0.0 Xtf=0.0 Vtf=0.0 Itf=0.0 Tr=0.0 Kf=0.0 Af=1.0 Ptf=0.0 Xtb=0.0 Xti=3.0 Eg=1.11 Tnom=26.85 )
R5 _net0 _net5  100K tc1=0.0 tc2=0.0
R2 pos _net5  1.5K tc1=0.0 tc2=0.0
R3 neg _net5  1.5K tc1=0.0 tc2=0.0
R4 _net2 _net5  100K tc1=0.0 tc2=0.0
C1 pos _net6  1
C2 neg _net7  1
R8 _net8 _net3  50 tc1=0.0 tc2=0.0
R9 0 IF  1.5K tc1=0.0 tc2=0.0
I1 0 _net4  DC 0 SIN(0 1U 1K 0 0 0) AC 1U ACPHASE 0
V3 _net3 0 DC 0 SIN(0 0.5 10K 0 0 0) AC 0.5 ACPHASE 0
LTRAN4_L1 _net8 0 1
LTRAN4_L2 _net2 _net0 1
KTRAN4 LTRAN4_L1 LTRAN4_L2 0.99
LTRAN5_L1 _net6 _net7 1
LTRAN5_L2 IF 0 1
KTRAN5 LTRAN5_L1 LTRAN5_L2 0.99
I2 0 _net4 DC 2U
V2 _net5 0 DC 10

.control

op
print v(IF) v(neg) v(pos)   > spice4qucs.dc1.ngspice.dc.print
destroy all
reset

tran 5e-07 0.0001 0
set specwindow=hanning
linearize v(IF) v(neg) v(pos)
fft v(IF) v(neg) v(pos)
write spice4qucs.fft1.plot v(IF) v(neg) v(pos)
destroy all
reset

tran 4e-06 0.002 0
write spice4qucs.tr1.plot v(IF) v(neg) v(pos)
destroy all
reset

exit
.endc
.END
