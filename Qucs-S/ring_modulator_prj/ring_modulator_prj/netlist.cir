* Qucs 26.1.0  C:/Users/Administrator/Desktop/58553868-f4bf-4f5f-876c-414b53bdac49/ring_modulator_prj/ring_modulator_optimized.sch
.INCLUDE "C:/Program Files/Qucs-S/share/qucs-s/xspice_cmlib/include/ngspice_mathfunc.inc"

.SUBCKT Transformers_TransformerPS1S2  gnd nPplus nPneg nSplus nSneg nSPct L1=0.5 L2=0.125 L3=0.125 K12=0.99 K13=0.99 K23=0.99 Rp=2 Rs1=1 Rs2=1
L1 nP1  nPneg {L1}
L2 nSPplus  nSPct {L2}
L3 nSPct  nSPneg {L3}
R1 nPplus nP1  {RP}
K13 L1 L3 {K13}
K12 L1 L2 {K12}
K23 L2 L3 {K23}
R2 nSneg nSPneg  {RS2}
R3 nSPplus nSplus  {RS1}
.ENDS

R1 _net0 RF  50 tc1=0.0 tc2=0.0
V1 _net0 0 DC 0 SIN(0 1M 7MEG 0 0 0) AC 1M ACPHASE 0

D1 lo1  _net1 HS_Schottky
D4 _net1  lo2 HS_Schottky
D2 _net2  lo1 HS_Schottky
D3 lo2  _net2 HS_Schottky
V2 _net3 0 DC 0 SIN(0 1 15MEG 0 0 0) AC 1 ACPHASE 0
XTRAN1 0 RF 0 _net1 _net2 out Transformers_TransformerPS1S2 L1=100U L2=100U L3=100U K12=0.99 K13=0.99 K23=0.99 Rp=100M Rs1=100M Rs2=100M
XTRAN2 0 LO 0 lo1 lo2 0 Transformers_TransformerPS1S2 L1=100U L2=100U L3=100U K12=0.99 K13=0.99 K23=0.99 Rp=100M Rs1=100M Rs2=100M
R2 out 0  50 tc1=0.0 tc2=0.0
R3 _net3 LO  500 tc1=0.0 tc2=0.0
.MODEL HS_Schottky D(Is=10n Rs=6 Cjo=1p Tt=10p Bv=70 Ibv=10u)

.control

tran 1.66667e-08 0.0001 0
set specwindow=hanning
linearize v(LO) v(RF) v(lo1) v(lo2) v(out)
fft v(LO) v(RF) v(lo1) v(lo2) v(out)
write spice4qucs.fft1.plot v(LO) v(RF) v(lo1) v(lo2) v(out)
destroy all
reset

tran 2e-09 2e-05 0
write spice4qucs.tr1.plot v(LO) v(RF) v(lo1) v(lo2) v(out)
destroy all
reset

exit
.endc
.END
