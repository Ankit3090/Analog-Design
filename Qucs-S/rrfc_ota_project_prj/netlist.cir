* Qucs 26.1.0  C:/Users/Administrator/Desktop/4efab355-08a4-4c9c-89b2-b413b3aecc58/rrfc_ota_project_prj/rrfc_ota.sch
.INCLUDE "C:/Program Files/Qucs-S/share/qucs-s/xspice_cmlib/include/ngspice_mathfunc.inc"
.INCLUDE "C:/Users/Administrator/Desktop/4efab355-08a4-4c9c-89b2-b413b3aecc58/rrfc_ota_project_prj/rrfc_models.lib"
M4 NODE_X  vin1  _net0  _net0 nmos_350
M2 _net1  vin1  FOLD_L  _net1 pmos_350
M1 _net1  vin2  FOLD_R  _net1 pmos_350
M3 NODE_Y  vin2  _net0  _net0 nmos_350
M14 VBN  VBN  0  0 nmos_350 W=5u L=1u
M15 vdd  VBP  VBP  vdd pmos_350 W=15u L=1u
M17 VBPCAS  VBN  0  0 nmos_350 W=5u L=1u
MX2 vdd  VBP  _net1  vdd pmos_350 W=30u L=1u
M5 vdd  VBP  NODE_X  vdd pmos_350 W=30u L=1u
M6 vdd  VBP  NODE_Y  vdd pmos_350 W=30u L=1u
M11 FOLD_L  FOLD_L  0  0 nmos_350 W=10u L=1u
M12 FOLD_R  FOLD_L  0  0 nmos_350 W=10u L=1u
V1 vdd 0 DC 3.3
V2 vin1 0 DC 1.65

M16 VBP  VBPCAS  VBPCAS  VBP pmos_350 W=15u L=1u
M13 VBNCAS  VBNCAS  VBN  VBN nmos_350 W=5u L=1u
M7 NODE_X  VBPCAS  _net2  NODE_X pmos_350 W=15u L=1u
M8 NODE_Y  VBPCAS  vout  NODE_Y pmos_350 W=15u L=1u
M9 _net2  VBNCAS  FOLD_L  FOLD_L nmos_350 W=5u L=1u
M10 vout  VBNCAS  FOLD_R  FOLD_R nmos_350 W=5u L=1u
V3 vin2 0 DC 1.65
V4 vout 0 DC 1.65
I3 vdd VBNCAS DC 20U
MX3 _net0  VBN  0  0 nmos_350 W=10u L=1u

.control

op
print v(FOLD_L) v(FOLD_R) v(NODE_X) v(NODE_Y) v(VBN) v(VBNCAS) v(VBP) v(VBPCAS) v(vdd) v(vin1) v(vin2) v(vout)   > spice4qucs.dc1.ngspice.dc.print
destroy all
reset

op
show m > C:/Users/Administrator/Desktop/4efab355-08a4-4c9c-89b2-b413b3aecc58/rrfc_ota_project_prj/op_results.txt
destroy all
reset

exit
.endc
.END
